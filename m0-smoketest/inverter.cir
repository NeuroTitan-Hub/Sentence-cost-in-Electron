* M0 smoke test: one sky130 inverter (tt corner, 27 C), energy per transition at 1.8 V
* Point this at your sky130A install (volare version c6d73a35f524070e85faff4a6a9eef49553ebc2b):
.lib "sky130A/libs.tech/ngspice/sky130.lib.spice" tt
.option temp=27
Vdd vdd 0 1.8
Vin in 0 PULSE(0 1.8 0.5n 20p 20p 1n 2n)
XMP out in vdd vdd sky130_fd_pr__pfet_01v8 w=1.0 l=0.15
XMN out in 0 0 sky130_fd_pr__nfet_01v8 w=0.5 l=0.15
Cload out 0 2f
.tran 1p 4.5n
.control
run
meas tran tphl trig v(in) val=0.9 rise=1 targ v(out) val=0.9 fall=1
meas tran tplh trig v(in) val=0.9 fall=1 targ v(out) val=0.9 rise=1
meas tran qcycle integ i(Vdd) from=0.5n to=2.5n
let ecycle = -qcycle*1.8
print ecycle
quit
.endc
.end
